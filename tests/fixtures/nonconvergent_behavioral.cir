* v(n)=v(n)^2+1 has no real operating point
BIMPOSSIBLE n 0 V=V(n)*V(n)+1
RLEAK n 0 1k
CSTATE n 0 1u
.end
